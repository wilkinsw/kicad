| Teraspeed (R) Labs.
| http://www.teraspeed.com
[IBIS Ver]   3.2
[Comment Char] |_char
[File Name]   adau1761.ibs
[File Rev]   3.1
[Source]  Teraspeed (R) Labs.
[Date]   03-23-2011
[Notes]   Quality Check of this IBIS model: Model Passes IBIS Check
   Model parses into ICX IS. Simulation done with Hyperlynx.
   1. MIN TYP MAX information is based on Temperature and Voltage
   characteristics only.
   2. Package data gained using Tektronix IConnect Software.
[Disclaimer]
| Use: Teraspeed Consulting Group LLC ("Teraspeed") has
| licensed IBIS models to specific integrated circuit
| suppliers ("IC Vendors") for use and distribution as
| follows: Each IC Vendor may use IBIS Models, and distribute
| them to IC Vendor's customers to use solely for developing
| printed circuit board designs. Users of this model may
| modify the IBIS model to suit its specific applications but
| rights to derivative works and such modifications shall belong
| to Teraspeed. No other distribution of these materials is
| permitted.
| DISCLAIMER OF WARRANTY: UNLESS OTHERWISE AGREED TO IN WRITING
| TERASPEED DISCLAIMS AND USER WAIVES ALL WARRANTIES, EXPRESS
| OR IMPLIED, INCLUDING WARRANTIES OF MERCHANTABILITY AND
| FITNESS FOR A PARTICULAR PURPOSE. IN NO EVENT SHALL
| TERASPEED BE LIABLE FOR ANY DIRECT OR INDIRECT DAMAGES,
| WHETHER IN CONTRACT OR TORT, INCLUDING, WITHOUT LIMITATION,
| LOST PROFITS, BUSINESS INTERRUPTION, OR LOST INFORMATION
| ARISING OUT OF THE USE OF OR THE INABILITY TO USE THE MODEL,
| EVEN IF TERASPEED HAS BEEN ADVISED OF THE POSSIBILITY OF SUCH
| DAMAGES.
[Copyright]
| This file is the legal property of Teraspeed (R) Labs Copyright(c) 2011.
| All other rights are reserved.
[Component]   ADAU1761
[Manufacturer] Analog Devices
[Package]
| variable   typ   min   max
R_pkg  1.01E-02   9.00E-03   1.10E-02
L_pkg  9.01E-10   8.90E-10   9.10E-10
C_pkg  1.60E-13   1.59E-13   1.61E-13
[Pin] signal_name  model_name  R_pin  L_pin C_pin
1   IOVDD   POWER   1.10E-02   9.10E-10   1.61E-13
2   MCLK   mclk   1.10E-02   9.10E-10   1.61E-13
3   ADDR0/_CLATCH   clatch   1.00E-02   9.00E-10   1.60E-13
4   JACKDET/MICIN   jackdet   9.00E-03   8.90E-10   1.59E-13
5   MICBIAS   term   9.00E-03   8.90E-10   1.59E-13
6   LAUX   term   1.00E-02   9.00E-10   1.60E-13
7   CM   term   1.00E-02   9.00E-10   1.60E-13
8   AVDD   POWER   1.10E-02   9.10E-10   1.61E-13
9   AGND   GND   1.10E-02   9.10E-10   1.61E-13
10   LINP   term   1.00E-02   9.00E-10   1.60E-13
11   LINN   term   1.00E-02   9.00E-10   1.60E-13
12   RINP   term   9.00E-03   8.90E-10   1.59E-13
13   RINN   term   9.00E-03   8.90E-10   1.59E-13
14   RAUX   term   1.00E-02   9.00E-10   1.60E-13
15   ROUTP   term   1.00E-02   9.00E-10   1.60E-13
16   ROUTN   term   1.10E-02   9.10E-10   1.61E-13
17   LOUTN   term   1.10E-02   9.10E-10   1.61E-13
18   LOUTP   term   1.00E-02   9.00E-10   1.60E-13
19   RHP   term   1.00E-02   9.00E-10   1.60E-13
20   LHP   term   9.00E-03   8.90E-10   1.59E-13
21   MONOOUT   term   9.00E-03   8.90E-10   1.59E-13
22   AGND   GND   1.00E-02   9.00E-10   1.60E-13
23   AVDD   POWER   1.00E-02   9.00E-10   1.60E-13
24   DVDDOUT   POWER   1.10E-02   9.10E-10   1.61E-13
25   DGND   GND   1.10E-02   9.10E-10   1.61E-13
26   ADC_SDATA/GPIO1 sdata_adc 1.00E-02   9.00E-10   1.60E-13
27   DAC_SDATA/GPIO0 sdata_dac 9.00E-03   8.90E-10   1.59E-13
28   BCLK/GPIO2   bclk   9.00E-03   8.90E-10   1.59E-13
29   LRCLK/GPIO3   lrclk   1.00E-02   9.00E-10   1.60E-13
30   ADDR1/CDATA   cdata   1.00E-02   9.00E-10   1.60E-13
31   SDA/COUT   sda_io   1.10E-02   9.10E-10   1.61E-13
32   SCL/CCLK   cclk   1.10E-02   9.10E-10   1.61E-13
[Model Selector] cclk
in_1.8v   input,iovdd=1.8v
in_pd_1.8v  input,iovdd=1.8v
in_pu_1.8v  input,iovdd=1.8v
in_2.5v   input,iovdd=2.5v
in_pd_2.5v  input,iovdd=2.5v
in_pu_2.5v  input,iovdd=2.5v
in_3.3v   input,iovdd=3.3v
in_pd_3.3v  input,iovdd=3.3v
in_pu_3.3v  input,iovdd=3.3v
[Model Selector] cdata
in_1.8v   input,iovdd=1.8v
in_pd_1.8v  input w/int pd,iovdd=1.8v
in_pu_1.8v  input w/int pu,iovdd=1.8v
in_2.5v   input,iovdd=2.5v
in_pd_2.5v  input w/int pd,iovdd=2.5v
in_pu_2.5v  input w/int pu,iovdd=2.5v
in_3.3v   input,iovdd=3.3v
in_pd_3.3v  input w/int pd,iovdd=3.3v
in_pu_3.3v  input w/int pu,iovdd=3.3v
[Model Selector] clatch
in_1.8v   input,iovdd=1.8v
in_pd_1.8v  input,iovdd=1.8v
in_pu_1.8v  input,iovdd=1.8v
in_2.5v   input,iovdd=2.5v
in_pd_2.5v  input,iovdd=2.5v
in_pu_2.5v  input,iovdd=2.5v
in_3.3v   input,iovdd=3.3v
in_pd_3.3v  input,iovdd=3.3v
in_pu_3.3v  input,iovdd=3.3v
[Model Selector] jackdet
in_1.8v   input,iovdd=1.8v
in_pd_1.8v  input,iovdd=1.8v
in_pu_1.8v  input,iovdd=1.8v
in_2.5v   input,iovdd=2.5v
in_pd_2.5v  input,iovdd=2.5v
in_pu_2.5v  input,iovdd=2.5v
in_3.3v   input,iovdd=3.3v
in_pd_3.3v  input,iovdd=3.3v
in_pu_3.3v  input,iovdd=3.3v
[Model Selector] mclk
mclk_1.8v  mclk input,iovdd=1.8v
mclk_2.5v  mclk input,iovdd=2.5v
mclk_3.3v  mclk input,iovdd=3.3v
[Model Selector] bclk
io_lo_1.8v   lo io,iovdd=1.8v
io_lo_pd_1.8v  lo io w/int pd,iovdd=1.8v
io_lo_pu_1.8v  lo io w/int pu,iovdd=1.8v
io_lo_2.5v   lo io,iovdd=2.5v
io_lo_pd_2.5v  lo io w/int pd,iovdd=2.5v
io_lo_pu_2.5v  lo io w/int pu,iovdd=2.5v
io_lo_3.3v   lo io,iovdd=3.3v
io_lo_pd_3.3v  lo io w/int pd,iovdd=3.3v
io_lo_pu_3.3v  lo io w/int pu,iovdd=3.3v
[Model Selector] lrclk
io_lo_1.8v   lo io,iovdd=1.8v
io_lo_pd_1.8v  lo io w/int pd,iovdd=1.8v
io_lo_pu_1.8v  lo io w/int pu,iovdd=1.8v
io_lo_2.5v   lo io,iovdd=2.5v
io_lo_pd_2.5v  lo io w/int pd,iovdd=2.5v
io_lo_pu_2.5v  lo io w/int pu,iovdd=2.5v
io_lo_3.3v   lo io,iovdd=3.3v
io_lo_pd_3.3v  lo io w/int pd,iovdd=3.3v
io_lo_pu_3.3v  lo io w/int pu,iovdd=3.3v
[Model Selector] sda_io
io_lo_1.8v   lo io,iovdd=1.8v
io_lo_pd_1.8v  lo io w/int pd,iovdd=1.8v
io_lo_pu_1.8v  lo io w/int pu,iovdd=1.8v
od_lo_1.8v   lo open drain io,iovdd=1.8v
od_lo_pd_1.8v  lo open drain io w/int pd,iovdd=1.8v
od_lo_pu_1.8v  lo open drain io w/int pu,iovdd=1.8v
io_lo_2.5v   lo io,iovdd=2.5v
io_lo_pd_2.5v  lo io w/int pd,iovdd=2.5v
io_lo_pu_2.5v  lo io w/int pu,iovdd=2.5v
od_lo_2.5v   lo open drain io,iovdd=2.5v
od_lo_pu_2.5v  lo open drain io w/int pu,iovdd=2.5v
od_lo_pd_2.5v  lo open drain io w/int pd,iovdd=2.5v
io_lo_3.3v   lo io,iovdd=3.3v
io_lo_pd_3.3v  lo io w/int pd,iovdd=3.3v
io_lo_pu_3.3v  lo io w/int pu,iovdd=3.3v
od_lo_3.3v   lo open drain io,iovdd=3.3v
od_lo_pd_3.3v  lo open drain io w/int pd,iovdd=3.3v
od_lo_pu_3.3v  lo open drain io w/int pu,iovdd=3.3v
io_hi_1.8v   hi io,iovdd=1.8v
io_hi_pd_1.8v  hi io w/int pd,iovdd=1.8v
io_hi_pu_1.8v  hi io w/int pu,iovdd=1.8v
od_hi_1.8v   hi open drain io,iovdd=1.8v
od_hi_pd_1.8v  hi open drain io w/int pd,iovdd=1.8v
od_hi_pu_1.8v  hi open drain io w/int pu,iovdd=1.8v
io_hi_2.5v   hi io,iovdd=2.5v
io_hi_pd_2.5v  hi io w/int pd,iovdd=2.5v
io_hi_pu_2.5v  hi io w/int pu,iovdd=2.5v
od_hi_2.5v   hi open drain io,iovdd=2.5v
od_hi_pd_2.5v  hi open drain io w/int pd,iovdd=2.5v
od_hi_pu_2.5v  hi open drain io w/int pu,iovdd=2.5v
io_hi_3.3v   hi io,iovdd=3.3v
io_hi_pd_3.3v  hi io w/int pd,iovdd=3.3v
io_hi_pu_3.3v  hi io w/int pu,iovdd=3.3v
od_hi_3.3v   hi open drain io,iovdd=3.3v
od_hi_pd_3.3v  hi open drain io w/int pd,iovdd=3.3v
od_hi_pu_3.3v  hi open drain io w/int pu,iovdd=3.3v
[Model Selector] sdata_adc
io_lo_1.8v   lo io,iovdd=1.8v
io_lo_pd_1.8v  lo io w/int pd,iovdd=1.8v
io_lo_pu_1.8v  lo io w/int pu,iovdd=1.8v
io_lo_2.5v   lo io,iovdd=2.5v
io_lo_pd_2.5v  lo io w/int pd,iovdd=2.5v
io_lo_pu_2.5v  lo io w/int pu,iovdd=2.5v
io_lo_3.3v   lo io,iovdd=3.3v
io_lo_pd_3.3v  lo io w/int pd,iovdd=3.3v
io_lo_pu_3.3v  lo io w/int pu,iovdd=3.3v
[Model Selector] sdata_dac
io_lo_1.8v   lo io,iovdd=1.8v
io_lo_pd_1.8v  lo io w/int pd,iovdd=1.8v
io_lo_pu_1.8v  lo io w/int pu,iovdd=1.8v
io_lo_2.5v   lo io,iovdd=2.5v
io_lo_pd_2.5v  lo io w/int pd,iovdd=2.5v
io_lo_pu_2.5v  lo io w/int pu,iovdd=2.5v
io_lo_3.3v   lo io,iovdd=3.3v
io_lo_pd_3.3v  lo io w/int pd,iovdd=3.3v
io_lo_pu_3.3v  lo io w/int pu,iovdd=3.3v
[Model] term
Model_type Terminator
C_comp   0pF 0pF 0pF
| variable   typ   min   max
[Voltage Range]   3.30000V 3.00000V 3.60000V
[Temperature Range]   25   85   -40
| Models and submodels in the file (49): mclk_1.8v (Input), mclk_2.5v (Input), mclk_3.3v (Input), in_1.8v (Input), in_pd_1.8v (Input), in_pu_1.8v (Input), in_2.5v (Input), in_pd_2.5v (Input), in_pu_2.5v (Input), in_3.3v (Input), in_pd_3.3v (Input), in_pu_3.3v (Input), io_lo_1.8v (I/O), io_lo_pd_1.8v (I/O), io_lo_pu_1.8v (I/O), io_lo_2.5v (I/O), io_lo_pd_2.5v (I/O), io_lo_pu_2.5v (I/O), io_lo_3.3v (I/O), io_lo_pd_3.3v (I/O), io_lo_pu_3.3v (I/O), io_hi_1.8v (I/O), io_hi_pd_1.8v (I/O), io_hi_pu_1.8v (I/O), io_hi_2.5v (I/O), io_hi_pd_2.5v (I/O), io_hi_pu_2.5v (I/O), io_hi_3.3v (I/O), io_hi_pd_3.3v (I/O), io_hi_pu_3.3v (I/O), od_lo_1.8v (I/O_open_drain), od_lo_pd_1.8v (I/O_open_drain), od_lo_pu_1.8v (I/O_open_drain), od_lo_2.5v (I/O_open_drain), od_lo_pd_2.5v (I/O_open_drain), od_lo_pu_2.5v (I/O_open_drain), od_lo_3.3v (I/O_open_drain), od_lo_pd_3.3v (I/O_open_drain), od_lo_pu_3.3v (I/O_open_drain), od_hi_1.8v (I/O_open_drain), od_hi_pd_1.8v (I/O_open_drain), od_hi_pu_1.8v (I/O_open_drain), od_hi_2.5v (I/O_open_drain), od_hi_pd_2.5v (I/O_open_drain), od_hi_pu_2.5v (I/O_open_drain), od_hi_3.3v (I/O_open_sink), od_hi_pd_3.3v (I/O_open_drain), od_hi_pu_3.3v (I/O_open_drain), term (Terminator)
